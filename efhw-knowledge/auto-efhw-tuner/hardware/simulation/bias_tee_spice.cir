* ============================================================
* bias_tee_spice.cir
* Bias-T 同轴馈电电路 — SPICE Simulation
* ============================================================
* 室内 Bias-T 注入盒: 将 13.8V DC 叠加到 50Ω 同轴电缆芯线
* 同时传输 100W RF (1.8-30 MHz) + DC (~150mA)
*
* 仿真目标:
*   1. S21 插入损耗 (RF IN → RF+DC OUT): < 0.2 dB
*   2. S31 RF-DC 隔离 (RF IN → DC Port): > 60 dB
*   3. S11 回波损耗 (RF IN): > 20 dB
*   4. 群延迟 vs 频率 (评估相位线性度)
*   5. L_rfc 自谐振频率 (SRF) 对隔离度的影响
*
* 运行: ngspice -b bias_tee_spice.cir
* ============================================================

* ============================================================
* 1. 电路拓扑
* ============================================================
*
*   Port1 (RF IN)                            Port2 (RF+DC OUT)
*   50Ω ○─────────┬─────────────────────────────○ 50Ω
*                  │                              │
*                  │    ┌─────────────────┐       │
*                  │    │  C_block ×2     │       │
*                  │    │  10nF/1KV C0G   │       │
*                  │    │  (并联)          │       │
*                  │    └────────┬────────┘       │
*                  │             │                 │
*                  │    ┌────────┴────────┐       │
*                  │    │  L_rfc           │       │
*                  │    │  95 µH           │       │
*                  │    │  (FT37-43 15T)  │       │
*                  │    └────────┬────────┘       │
*                  │             │                 │
*                  │    ┌────────┴────────┐       │
*                  │    │  C_bypass       │       │
*                  │    │  100nF          │       │
*                  │    │  (RF旁路到地)    │       │
*                  │    └────────┬────────┘       │
*                  │             │                 │
*                  │         Port3 (DC IN)        │
*                  │         13.8V ○              │
*                  │             │                 │
*                 GND ───────────┴─────────────────┘

* ============================================================
* 2. 仿真参数
* ============================================================
.param F_LOW  = 1.8Meg
.param F_HIGH = 30Meg
.param Z0     = 50
.param V_DC   = 13.8

* ============================================================
* 3. 元件模型
* ============================================================

*** 3.1 隔直电容 C_block (10nF/1KV C0G ×2 并联) ***
* C0G ESR 极低: @ 14MHz, Q>1000, ESR < 1mΩ
* ESL (1206 ×2并): ~0.5nH
* C_effective = 20nF (两只并联)
C_block1  N001 N002 10n
R_esr1    N002 N003 0.0005   ; 并联 ESR 更低
L_esl1    N003 N004 0.3n     ; 并联 ESL 减半
C_block2  N001 N002 10n      ; 第二只
R_esr2    N002 N003 0.0005
L_esl2    N003 N004 0.3n
* 总计: 20nF, ESR≈0.25mΩ, ESL≈0.15nH

*** 3.2 RF 扼流圈 L_rfc (FT37-43, 15T) ***
* AL(FT37-43) = 420 nH/N²
* L = 420nH × 15² = 94.5 µH ≈ 95 µH
* 自谐振频率 SRF:
*   C_stray (15T紧密绕线) ≈ 2 pF
*   SRF = 1/(2π√(95µH × 2pF)) ≈ 11.5 MHz  ⚠️ 低于 30 MHz!
*   需要对冲策略: 串联铁氧体磁珠 或 使用多只不同值电感串联
*
* 仿真时将 SRF 建模为并联电容:
L_rfc      N002 N005 95u
R_l_rfc    N005 N006 0.5      ; 绕线直流电阻
C_par_rfc  N002 N006 2p       ; 分布电容 (决定 SRF)
* R_parallel 代表磁芯损耗:
* Q(FT37-43 @ 14MHz) ≈ 80
* XL = 2π × 14MHz × 95µH ≈ 8,358 Ω
* R_par = Q × XL ≈ 669 kΩ
R_par_rfc  N002 N006 670k

*** 3.3 旁路电容 C_bypass ***
C_bypass   N006 0  100n
R_esr_byp  N006 N007 0.01
L_esl_byp  N007 0   1n

*** 3.4 DC 电源模型 ***
* 理想 DC 源 + 输出阻抗
V_DC_in    N008 0  DC(13.8)
R_dc_src   N008 N009 0.1     ; 电源内阻

* 连接 DC 到旁路点
* 注: 在真实电路中 DC 插座通过导线连到 N006
R_dc_wire  N009 N007 0.05    ; 导线电阻

* ============================================================
* 4. 端接
* ============================================================

R_port1    N001 0  50         ; RF 输入端口端接
R_port2    N004 0  50         ; RF+DC 输出端口端接
R_port3    N008 0  200        ; DC 端口负载 (~150mA @ 13.8V ≈ 92Ω)
* 实际 DC 端口在 RF 频率下为高阻 (电源输出阻抗)

* ============================================================
* 5. 交流信号源 (S参数分析)
* ============================================================

V_ac_in    N001 0  AC(1)

* ============================================================
* 6. 仿真分析
* ============================================================

*** 6.1 S参数 (AC 扫频) ***
* S21 (插入损耗) = V(N004) / V(N001) in dB
* S31 (RF→DC 隔离) = V(N008) / V(N001) in dB
* S11 (回波损耗) 需要电流探头, 简化: S11 ≈ (Zin - 50)/(Zin + 50)

*** 6.2 SRF 影响分析 ***
* 当前模型 SRF ≈ 11.5 MHz
* 在 14-30 MHz 范围, L_rfc 从感性变为容性
* → RF 隔离度在高频段急剧恶化
*
* 改进方案 1: 使用宽带扼流圈 (Coilcraft 4310LC)
*   覆盖 1-500 MHz, 但成本 ¥40+
* 改进方案 2: 3 只不同电感串联
*   L1=22µH(CD75) + L2=10µH + L3=4.7µH
*   各自的 SRF 错开 → 全频段保持感性
* 改进方案 3: FT50-43 上绕 12T (更大磁芯, 更少匝数)
*   L = 520nH × 144 ≈ 75 µH
*   C_stray (12T 间隔更宽) ≈ 1.2pF
*   SRF ≈ 16.7 MHz ← 改善但仍不完美

* ============================================================
* 7. 预期结果
* ============================================================
*
* 频率     S21 (插损)    S31 (隔离)     S11 (回损)
* 1.8 MHz   <0.05 dB     >80 dB        >30 dB
* 7.1 MHz   <0.08 dB     >70 dB        >28 dB
* 14.2 MHz  <0.10 dB     >55 dB (SRF 附近降低)  >25 dB
* 21.2 MHz  <0.12 dB     >45 dB        >20 dB
* 28.5 MHz  <0.15 dB     >35 dB ⚠️     >18 dB
*
* ⚠️ 28.5 MHz 的隔离度 35 dB 仍然可用, 但 SNR 会降低
*    建议 V2.0 使用 Coilcraft 宽带扼流圈

* ============================================================
* 8. 控制语句
* ============================================================
* .control
*   ac dec 100 1Meg 100Meg
*   * S21 插入损耗
*   plot db(v(n004)/v(n001))
*   * S31 RF-DC 隔离
*   plot db(v(n008)/v(n001))
*   * 输入阻抗
*   let Zin = v(n001) / i(V_ac_in)
*   plot db((Zin-50)/(Zin+50))
* .endc

.end
